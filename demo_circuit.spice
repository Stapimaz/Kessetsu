* NetLang Generated SPICE Netlist
V_Vcc 7 0 12V
R_R1 7 1 10k
R_R2 1 0 2.2k
R_Rc 7 3 1k
R_Re 5 0 100
Q_Q1 3 1 5 2N3904
C_Cin 6 1 10uF
C_Cout 3 4 10uF
C_Ce 5 0 100uF
V_Vin 6 0 1V
R_Rload 4 0 10k

.control
op
print all
quit
.endc
