* Kessetsu structured OP fixture
V_INPUT in 0 5
R_TOP in out 1k
R_BOTTOM out 0 1k

.control
set wr_singlescale
set wr_vecnames
op
wrdata kessetsu-analysis-000-op.data all
quit
.endc
.end
