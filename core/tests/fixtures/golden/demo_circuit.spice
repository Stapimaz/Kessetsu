* NetLang Generated SPICE Netlist
C_Ce N_Ce_p1 0 1e-4
C_Cin N_Cin_p1 N_Cin_p2 1e-5
C_Cout N_Cout_p1 N_Cout_p2 1e-5
Q_Q1 N_Cout_p1 N_Cin_p2 N_Ce_p1 2N3904
R_R1 N_R1_p1 N_Cin_p2 10000
R_R2 N_Cin_p2 0 2200
R_Rc N_R1_p1 N_Cout_p1 1000
R_Re N_Ce_p1 0 100
R_Rload N_Cout_p2 0 10000
V_Vcc N_R1_p1 0 12
V_Vin N_Cin_p1 0 1

* Standard Models
.model 2N3904 NPN (Is=6.734f Xti=3 Eg=1.11 Vaf=74.03 Bf=416.4 Ne=1.259 Ise=6.734f Ikf=66.78m Xtb=1.5 Br=.7371 Nc=2 Isc=0 Ikr=0 Rc=1 Cjc=3.638p Mjc=.3085 Vjc=.75 Fc=.5 Cje=4.493p Mje=.2593 Vje=.75 Tr=239.5n Tf=301.2p Itf=.4 Vtf=4 Xtf=2 Rb=10)

.control
set wr_singlescale
set wr_vecnames
set numdgt=17
op
wrdata netlang-analysis-000-op.data all
print all
quit
.endc
