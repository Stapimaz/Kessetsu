* NetLang Generated SPICE Netlist
C_C1 N_C1_p1 my_signal 0.00009999999999999999
I_I1 my_power 0 SINE(0 0.005 10000)
Q_Q1 N_Q1_c N_C1_p1 my_power 2N3906
Q_Q2 my_signal N_Q1_c 0 2N3904
R_R1 my_power N_C1_p1 10000
R_R2 N_Q1_c 0 5000
V_V1 my_power 0 10

* Standard Models
.model 2N3904 NPN (Is=6.734f Xti=3 Eg=1.11 Vaf=74.03 Bf=416.4 Ne=1.259 Ise=6.734f Ikf=66.78m Xtb=1.5 Br=.7371 Nc=2 Isc=0 Ikr=0 Rc=1 Cjc=3.638p Mjc=.3085 Vjc=.75 Fc=.5 Cje=4.493p Mje=.2593 Vje=.75 Tr=239.5n Tf=301.2p Itf=.4 Vtf=4 Xtf=2 Rb=10)
.model 2N3906 PNP (Is=1.41f Xti=3 Eg=1.11 Vaf=18.7 Bf=227.3 Ne=1.5 Ise=0 Ikf=80m Xtb=1.5 Br=4.977 Nc=2 Isc=0 Ikr=0 Rc=2.5 Cjc=9.728p Mjc=.5776 Vjc=.75 Fc=.5 Cje=8.063p Mje=.3677 Vje=.75 Tr=33.42n Tf=179.3p Itf=.4 Vtf=4 Xtf=6 Rb=10)

.control
tran 1us 10ms
meas tran max_v_my_signal MAX V(my_signal)
meas tran peak_i_v1 MAX I(V_V1)
print all
quit
.endc
