* NetLang Generated SPICE Netlist
V_B1 5 0 9V
R_myDiv_R1 5 2 10k
R_myDiv_R2 2 0 20k
Q_Q1 3 2 0 NPN
R_R3 6 4 1k
